** Generated for: hspiceD
** Generated on: Nov  5 12:52:50 2025
** Design library name: ECE555
** Design cell name: NOR
** Design view name: schematic

** Library name: ECE555
** Cell name: NOR
** View name: schematic
mn1 out in1 vss! vss! nmos_rvt w=81e-9 l=20e-9 nfin=3
mn0 out in0 vss! vss! nmos_rvt w=81e-9 l=20e-9 nfin=3
mp3 net2 in1 vdd! vdd! pmos_rvt w=162e-9 l=20e-9 nfin=6
mp2 out in0 net2 vdd! pmos_rvt w=162e-9 l=20e-9 nfin=6
.END
