ADE simulation setup
Test ECE555_NOR_1: ECE555/NOR/schematic, simulator hspiceD
Run mode: Single Run, Sweeps and Corners
