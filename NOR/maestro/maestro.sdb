ADE simulation setup
Run mode: Single Run, Sweeps and Corners
Tests:
  ECE555_NOR_1: ECE555/NOR/schematic, simulator hspiceD
