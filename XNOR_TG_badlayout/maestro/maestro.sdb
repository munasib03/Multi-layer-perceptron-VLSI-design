ADE simulation setup
Run mode: Single Run, Sweeps and Corners
Tests:
  ECE555_XNOR_TG_1: ECE555/XNOR_TG/schematic, simulator hspiceD
