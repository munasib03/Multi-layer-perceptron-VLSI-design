ADE simulation setup
Test ECE555_XNOR_TG_1: ECE555/XNOR_TG/schematic, simulator hspiceD
