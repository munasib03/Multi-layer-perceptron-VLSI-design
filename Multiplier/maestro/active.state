ADE simulation setup
Test ECE555_Multiplier_1: ECE555/Multiplier/schematic, simulator hspiceD
Run mode: Single Run, Sweeps and Corners
