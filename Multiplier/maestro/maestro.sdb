ADE simulation setup
Run mode: Single Run, Sweeps and Corners
Tests:
  ECE555_Multiplier_1: ECE555/Multiplier/schematic, simulator hspiceD
